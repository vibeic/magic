* tinytop schematic (CORRUPTED) -- n12 miswired to in
.subckt buf A Z VPWR VGND
.ends
.subckt tinytop in out VSUBS
Xu0 in  n01 VPWR VGND buf
Xu1 n01 in  VPWR VGND buf
Xu2 in  out VPWR VGND buf
.ends
