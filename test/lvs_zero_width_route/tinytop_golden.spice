* tinytop schematic (golden) -- abstract buf cells chained
.subckt buf A Z VPWR VGND
.ends
.subckt tinytop in out VSUBS
Xu0 in  n01 VPWR VGND buf
Xu1 n01 n12 VPWR VGND buf
Xu2 n12 out VPWR VGND buf
.ends
